*CMOS inverter
.include /home/sharo/PROJET_IA/LIB_Sharon/ciel/sky130A/libs.tech/ngspice/sky130copy.lib.spice

************************************************
* Parameters (Python/RL can override these)
************************************************
.param vdd=1.80
.param temp=25
.param wn=0.42u
.param wp=0.84u
.param l =0.15u
.param cload=5f
.param tr=50p
.param tf=50p
.param pw=1n
.param per=2n
.param tsim=6n

.temp {temp}

************************************************
* Supplies and stimulus
************************************************
VDD VP 0 {vdd}
VIN A  0 PULSE(0 {vdd} 0 {tr} {tf} {pw} {per})

************************************************
* DUT: parameterized inverter (Wn/Wp, L fixed)
************************************************
.subckt inv_param A Y VP VN params: wn=0.42u wp=0.84u l=0.15u
Mp0 Y A VP VP sky130_fd_pr__pfet_01v8 W={wp} L={l}
Mn0 Y A VN VN sky130_fd_pr__nfet_01v8 W={wn} L={l}
.ends inv_param

XINV A Y VP 0 inv_param wn={wn} wp={wp} l={l}

************************************************
* Load
************************************************
CLOAD Y 0 {cload}

************************************************
* Measurements (delay 20/80 + example static power)
************************************************
.param rlow=0.2
.param rhigh=0.8
.param vlow ={rlow*vdd}
.param vhigh={rhigh*vdd}

.tran 1p {tsim}

* Input rising -> output falling
.meas tran delay_fall TRIG v(A) VAL={vhigh} RISE=1 TARG v(Y) VAL={vhigh} FALL=1
* Input falling -> output rising
.meas tran delay_rise TRIG v(A) VAL={vlow}  FALL=1 TARG v(Y) VAL={vlow}  RISE=1

* Example static power averages in two stable windows (adapt if you change timings)
.param t0a=0.2n t0b=0.8n
.param t1a=1.2n t1b=1.8n
.meas tran pstat_in0 AVG par('-(v(VP)*i(VDD) + v(A)*i(VIN))') FROM={t0a} TO={t0b}
.meas tran pstat_in1 AVG par('-(v(VP)*i(VDD) + v(A)*i(VIN))') FROM={t1a} TO={t1b}

.end
