* CMOS inverter - Simulation pour optimisation RL
.lib "/home/sharo/PROJET_IA/LIB_Sharon/ciel/sky130A/libs.tech/ngspice/sky130copy.lib.spice" tt
*.lib "/home/sharo/PROJET_IA/LIB_Sharon/ciel/sky130A/libs.tech/ngspice/corners/tt.spice"
************************************************
* Parameters
************************************************
.param vdd=1.80
.param temp=25
.param wn=650000u
.param wp=1e+06u
.param l =150000u
.param cload=5f
.param tr=50p
.param tf=50p
.param pw=1n
.param per=2n
.param tsim=6n

* Constantes de la bibliothèque sky130_fd_sc_hd: https://skywater-pdk.readthedocs.io/en/main/contents/libraries/foundry-provided.html

.param h_cell = 2.72
.param pitch = 0.46
.param w_fixed = 0.16

.temp {temp}

************************************************
* Supplies and stimulus
************************************************
VDD VP 0 {vdd}
VIN A  0 PULSE(0 {vdd} 0 {tr} {tf} {pw} {per})

************************************************
* DUT: parameterized inverter
************************************************
.subckt inv_param A VGND VNB VPB VPWR Y
X0 VGND A Y VNB sky130_fd_pr__nfet_01v8 w={wn} l={l}
X1 VPWR A Y VPB sky130_fd_pr__pfet_01v8_hvt w={wp} l={l}
.ends inv_param

* Ordre des broches : A  VGND  VNB  VPB  VPWR  Y
XINV A 0 0 VP VP Y inv_param

************************************************
* Load
************************************************
CLOAD Y 0 {cload}

************************************************
* Measurements & Characterization
************************************************
.param rlow=0.2
.param rhigh=0.8
.param vlow ={rlow*vdd}
.param vhigh={rhigh*vdd}

.tran 1p {tsim}

* 1. SURFACE (Area)
* --- Mesure de la Surface Réelle (en escalier) ---
.meas tran cell_area param='h_cell * ceil((max(wn, wp) + w_fixed) / pitch) * pitch'

* --- Mesure de la Surface Transistors (pour l'IA) ---
.meas tran active_area param='(wn + wp) * 0.15'

* 2. DELAIS (Transition delays)
.meas tran delay_fall TRIG v(A) VAL={vhigh} RISE=1 TARG v(Y) VAL={vhigh} FALL=1
.meas tran delay_rise TRIG v(A) VAL={vlow}  FALL=1 TARG v(Y) VAL={vlow}  RISE=1

* 3. CONSOMMATION STATIQUE (Static Power)
.param t0a=0.2n t0b=0.8n
.param t1a=1.2n t1b=1.8n
* A=1 (entrée haute) entre 0.2ns et 0.8ns
.meas tran pstat_in1 AVG par('-(v(VP)*i(VDD) + v(A)*i(VIN))') FROM={t0a} TO={t0b}
.meas tran pstat_vdd_in1 AVG par('-(v(VP)*i(VDD))') FROM={t0a} TO={t0b}

* A=0 (entrée basse) entre 1.2ns et 1.8ns
.meas tran pstat_in0 AVG par('-(v(VP)*i(VDD) + v(A)*i(VIN))') FROM={t1a} TO={t1b}
.meas tran pstat_vdd_in0 AVG par('-(v(VP)*i(VDD))') FROM={t1a} TO={t1b}
.meas tran ymean_a1 AVG v(Y) FROM={t0a} TO={t0b}
.meas tran ymean_a0 AVG v(Y) FROM={t1a} TO={t1b}

* 4. CONSOMMATION DYNAMIQUE (Dynamic Energy)
* Mesure de l'intégrale de la puissance totale entre deux points
.meas tran etotal_trans INTEG par('-(v(VP)*i(VDD) + v(A)*i(VIN))') FROM=0.9n TO=1.1n

* Calcul de l'énergie dynamique en soustrayant la part statique
* Note : On utilise 'param' dans .meas pour combiner les résultats précédents
.meas tran edyn_val param='etotal_trans - (pstat_in0 * 0.2n)'

.end
