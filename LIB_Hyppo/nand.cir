* Fichier netlist de la Nand utilisée

.param vdd=1.8
.lib /home/tp-soa/Projet_SOA/PROJET_IA/.ciel/sky130A/libs.tech/ngspice/sky130tt.lib.spice tt
.include /home/tp-soa/Projet_SOA/PROJET_IA/.ciel/sky130A/libs.ref/sky130_fd_sc_hd/spice/sky130_fd_sc_hd_nand.spice

* --- Paramètres (Variables pour l'agent RL) ---
.param wn_val = 360000u
.param wp_val = 1e+06u

* --- Alimentation et signaux ---
Vpwr VPWR 0 1.8V
Vgnd VGND 0 0V
Va A 0 PWL(0 0  0.9n 0  1n 1.8  3.9n 1.8  4n 0)
Vb B 0 PWL(0 1.8  1.9n 1.8  2n 0  2.9n 0  3n 1.8)

* --- Instance de la NAND ---
X1 A B VGND VGND VPWR VPWR Y sky130_fd_sc_hd__nand2_1 wn={wn_val} wp={wp_val}

* --- Analyse Transitoire ---
.tran 0.01n 5n

* --- Mesures (Directives Directes) ---0
.meas tran cell_area PARAM='(wn_val + wp_val) * 2.72e+06u'

* 3. Délais : Temps de propagation (Input 50% -> Output 50%)
.meas tran tfall1 TRIG v(A) VAL=0.9 RISE=1 TARG v(Y) VAL=0.9 FALL=1
.meas tran trise1 TRIG v(B) VAL=0.9 FALL=1 TARG v(Y) VAL=0.9 RISE=1
.meas tran tfall2 TRIG v(B) VAL=0.9 RISE=1 TARG v(Y) VAL=0.9 FALL=2
.meas tran trise2 TRIG v(A) VAL=0.9 FALL=1 TARG v(Y) VAL=0.9 RISE=2

.end
